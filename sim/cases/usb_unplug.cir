* CASE usb_unplug: USB pulled while the lamp runs at 4000 K full, battery at 3.6 V (VERIFY E12: VSYS dip <= 0.3 V,
* no reset). On USB, VSYS is fed through D3 and Q1 is held off by VBUS on its gate. After the unplug the load
* drains C1 through D3 until Q1's body diode takes over; Q1's channel only turns on once R5 has pulled VBUS
* below VSYS_RAW - |VGS(th)|.
.param soc0=0.10 r5=10k
.include models.inc
.include boards.inc
Xcell batraw 0 LIPO soc0={soc0}
Vusb usb 0 5.0
Rusb usb u1 0.2
Lusb u1 u2 1u
Splug u2 vbusin plug 0 SPLUG
.model SPLUG SW(VT=0.5 VH=0.01 RON=10m ROFF=1e9)
Vplug plug 0 PWL(0 1 5m 1 5.001m 0)
Vsw swon 0 1
Vled ledon 0 1
Xmb vbusin batraw vsys vled swon ledon vbus vsysraw bat MAINPWR r5={r5}
Xcab vled 0 vledb gb CABLE
Vw dw 0 0.8875
Vz dz 0 0
Xlb vledb gb dw dz dz dz LEDBOARD
.tran 2u 250m 0 20u
.control
run
let iled = (v(vled)-v(vledb))/0.063
meas tran vsys_usb find v(vsys) at=4.9m
meas tran vsys_min min v(vsys) from=5m to=250m
meas tran vsys_bat find v(vsys) at=249m
meas tran iled_usb find iled at=4.9m
meas tran iled_min min iled from=5m to=250m
meas tran t_dip_end when v(vsys)=vsys_bat-0.05 rise=last
let dip = vsys_bat - v(vsys)
meas tran t_over when dip=0.3 cross=last
wrdata @DAT@ v(vsys) v(vbus) v(vsysraw) iled
.endc
.end
