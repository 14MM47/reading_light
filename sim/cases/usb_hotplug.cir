* CASE usb_hotplug: a USB-C charger (5.25 V, top of the 5 V +-5 % band) is plugged in while the lamp runs on the
* battery at 4000 K full. The cable inductance rings with C1 (10 uF, VBUS). Checks VBUS against the TVS and the
* MCP73831 abs max (7 V), and VSYS / VLED against the ATtiny and LP5012 abs max (6 V).
* USB cable: rusb (VBUS + GND, 0.1 Ohm short/heavy ... 0.3 Ohm long/thin) and 1 uH loop (PROVISIONAL).
.param soc0=0.30 rusb=0.1 vusb=5.25 lusb=1u q1gd=0 sch=0 vdet=4.3 usbid=0 ron_id=0.08 ce_r=1m ce_c=1f snub=0
.include models.inc
.include boards.inc
Xcell batraw 0 LIPO soc0={soc0}
Vusb usb 0 {vusb}
Rusb usb u1 {rusb}
Lusb u1 u2 {lusb}
Splug u2 vbusin plug 0 SPLUG
.model SPLUG SW(VT=0.5 VH=0.01 RON=10m ROFF=1e9)
Vplug plug 0 PWL(0 0 100u 0 100.01u 1)
Vsw swon 0 1
Vled ledon 0 1
Xmb vbusin batraw vsys vled swon ledon vbus vsysraw bat MAINPWR q1gd={q1gd} sch={sch} vdet={vdet} usbid={usbid} ron_id={ron_id} ce_r={ce_r} ce_c={ce_c} snub={snub}
Xcab vled 0 vledb gb CABLE
Vw dw 0 0.8875
Vz dz 0 0
Xlb vledb gb dw dz dz dz LEDBOARD
.tran 5n 400u 0 5n
.control
run
let iusb = i(lusb)
let icell_in = -i(v.xcell.vsense)
meas tran icell_in_max max icell_in from=100u to=400u
meas tran vbus_max max v(vbus) from=100u to=400u
meas tran vsysraw_max max v(vsysraw) from=100u to=400u
meas tran vce_max max v(xmb.lmce) from=100u to=400u
meas tran vbusin_max max v(vbusin) from=100u to=400u
meas tran iusb_pk max iusb from=100u to=400u
meas tran vsys_max max v(vsys) from=100u to=400u
meas tran vledb_max max v(vledb) from=100u to=400u
meas tran vsys_end find v(vsys) at=399u
wrdata @DAT@ iusb v(vbus) v(vsys) v(vledb) icell_in
.endc
.end
