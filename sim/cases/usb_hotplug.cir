* CASE usb_hotplug: a USB-C charger (5.25 V, top of the 5 V +-5 % band) is plugged in while the lamp runs on the
* battery at 4000 K full. The cable inductance rings with C1 (10 uF, VBUS). Checks VBUS against the TVS and the
* MCP73831 abs max (7 V), and VSYS / VLED against the ATtiny and LP5012 abs max (6 V).
* USB cable: rusb (VBUS + GND, 0.1 Ohm short/heavy ... 0.3 Ohm long/thin) and 1 uH loop (PROVISIONAL).
.param soc0=0.30 rusb=0.1 vusb=5.25
.include models.inc
.include boards.inc
Xcell batraw 0 LIPO soc0={soc0}
Vusb usb 0 {vusb}
Rusb usb u1 {rusb}
Lusb u1 u2 1u
Splug u2 vbusin plug 0 SPLUG
.model SPLUG SW(VT=0.5 VH=0.01 RON=10m ROFF=1e9)
Vplug plug 0 PWL(0 0 100u 0 100.01u 1)
Vsw swon 0 1
Vled ledon 0 1
Xmb vbusin batraw vsys vled swon ledon vbus vsysraw bat MAINPWR
Xcab vled 0 vledb gb CABLE
Vw dw 0 0.8875
Vz dz 0 0
Xlb vledb gb dw dz dz dz LEDBOARD
.tran 5n 400u 0 5n
.control
run
let iusb = i(lusb)
meas tran vbus_max max v(vbus) from=100u to=400u
meas tran vbusin_max max v(vbusin) from=100u to=400u
meas tran iusb_pk max iusb from=100u to=400u
meas tran vsys_max max v(vsys) from=100u to=400u
meas tran vledb_max max v(vledb) from=100u to=400u
meas tran vsys_end find v(vsys) at=399u
wrdata @DAT@ iusb v(vbus) v(vsys) v(vledb)
.endc
.end
